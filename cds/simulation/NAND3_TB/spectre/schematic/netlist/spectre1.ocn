simulator( 'spectre )
design(	 "/ubc/ece/home/ugrads/l/l6w0b/Desktop/Cadence_49820153/cds/simulation/NAND3_TB/spectre/schematic/netlist/netlist")
resultsDir( "/ubc/ece/home/ugrads/l/l6w0b/Desktop/Cadence_49820153/cds/simulation/NAND3_TB/spectre/schematic" )
modelFile(
    '("/ubc/ece/data/cmc2/kits/AMSKIT616_GPDK/tech/gpdk045_v_4_0/gpdk045/../models/spectre/gpdk045.scs" "tt")
)
analysis('tran ?stop "5n"  )
desVar(	  "T" 1n	)
envOption(
	'analysisOrder  list("pz" "dcmatch" "stb" "tran" "envlp" "ac" "dc" "noise" "xf" "sp" "pss" "pac" "pstb" "pnoise" "pxf" "psp" "qpss" "qpac" "qpnoise" "qpxf" "qpsp" "hb" "hbac" "hbnoise" "hbsp" "sens")
)
save( 'i "/I0/OUT" )
temp( 27 )
run()
selectResult( 'tran )
plot(getData("/I0/OUT") )
modelFile(
    '("/ubc/ece/data/cmc2/kits/AMSKIT616_GPDK/tech/gpdk045_v_4_0/gpdk045/../models/spectre/gpdk045.scs" "tt")
)
desVar(	  "T" 2n	)
run()
selectResult( 'tran )
plot(getData("/I0/OUT") )
modelFile(
    '("/ubc/ece/data/cmc2/kits/AMSKIT616_GPDK/tech/gpdk045_v_4_0/gpdk045/../models/spectre/gpdk045.scs" "tt")
)
desVar(	  "T" 500p	)
run()
selectResult( 'tran )
plot(getData("/I0/OUT") )
modelFile(
    '("/ubc/ece/data/cmc2/kits/AMSKIT616_GPDK/tech/gpdk045_v_4_0/gpdk045/../models/spectre/gpdk045.scs" "tt")
)
analysis('tran ?stop "25n"  )
desVar(	  "T" 5n	)
run()
selectResult( 'tran )
plot(getData("/I0/OUT") )
modelFile(
    '("/ubc/ece/data/cmc2/kits/AMSKIT616_GPDK/tech/gpdk045_v_4_0/gpdk045/../models/spectre/gpdk045.scs" "tt")
)
save( 'i /I0/OUT )
run()
v\ \/V4_PLUS\;\ tran\ \(V\) = vtime('tran "/V4_PLUS")
plot( v\ \/V4_PLUS\;\ tran\ \(V\) ?expr '( "v /V4_PLUS; tran (V)" ) )
v\ \/I0_OUT\;\ tran\ \(V\) = vtime('tran "/I0_OUT")
plot( v\ \/I0_OUT\;\ tran\ \(V\) ?expr '( "v /I0_OUT; tran (V)" ) )
modelFile(
    '("/ubc/ece/data/cmc2/kits/AMSKIT616_GPDK/tech/gpdk045_v_4_0/gpdk045/../models/spectre/gpdk045.scs" "tt")
)
run()
v\ \/V4_PLUS\;\ tran\ \(V\) = vtime('tran "/V4_PLUS")
plot( v\ \/V4_PLUS\;\ tran\ \(V\) ?expr '( "v /V4_PLUS; tran (V)" ) )
v\ \/I0_OUT\;\ tran\ \(V\) = vtime('tran "/I0_OUT")
plot( v\ \/I0_OUT\;\ tran\ \(V\) ?expr '( "v /I0_OUT; tran (V)" ) )
modelFile(
    '("/ubc/ece/data/cmc2/kits/AMSKIT616_GPDK/tech/gpdk045_v_4_0/gpdk045/../models/spectre/gpdk045.scs" "tt")
)
run()
v\ \/V4_PLUS\;\ tran\ \(V\) = vtime('tran "/V4_PLUS")
plot( v\ \/V4_PLUS\;\ tran\ \(V\) ?expr '( "v /V4_PLUS; tran (V)" ) )
v\ \/I0_OUT\;\ tran\ \(V\) = vtime('tran "/I0_OUT")
plot( v\ \/I0_OUT\;\ tran\ \(V\) ?expr '( "v /I0_OUT; tran (V)" ) )
modelFile(
    '("/ubc/ece/data/cmc2/kits/AMSKIT616_GPDK/tech/gpdk045_v_4_0/gpdk045/../models/spectre/gpdk045.scs" "tt")
)
run()
v\ \/V4_PLUS\;\ tran\ \(V\) = vtime('tran "/V4_PLUS")
plot( v\ \/V4_PLUS\;\ tran\ \(V\) ?expr '( "v /V4_PLUS; tran (V)" ) )
v\ \/I0_OUT\;\ tran\ \(V\) = vtime('tran "/I0_OUT")
plot( v\ \/I0_OUT\;\ tran\ \(V\) ?expr '( "v /I0_OUT; tran (V)" ) )
modelFile(
    '("/ubc/ece/data/cmc2/kits/AMSKIT616_GPDK/tech/gpdk045_v_4_0/gpdk045/../models/spectre/gpdk045.scs" "tt")
)
run()
v\ \/V4_PLUS\;\ tran\ \(V\) = vtime('tran "/V4_PLUS")
plot( v\ \/V4_PLUS\;\ tran\ \(V\) ?expr '( "v /V4_PLUS; tran (V)" ) )
v\ \/I0_OUT\;\ tran\ \(V\) = vtime('tran "/I0_OUT")
plot( v\ \/I0_OUT\;\ tran\ \(V\) ?expr '( "v /I0_OUT; tran (V)" ) )
modelFile(
    '("/ubc/ece/data/cmc2/kits/AMSKIT616_GPDK/tech/gpdk045_v_4_0/gpdk045/../models/spectre/gpdk045.scs" "tt")
)
run()
v\ \/V4_PLUS\;\ tran\ \(V\) = vtime('tran "/V4_PLUS")
plot( v\ \/V4_PLUS\;\ tran\ \(V\) ?expr '( "v /V4_PLUS; tran (V)" ) )
v\ \/I0_OUT\;\ tran\ \(V\) = vtime('tran "/I0_OUT")
plot( v\ \/I0_OUT\;\ tran\ \(V\) ?expr '( "v /I0_OUT; tran (V)" ) )
modelFile(
    '("/ubc/ece/data/cmc2/kits/AMSKIT616_GPDK/tech/gpdk045_v_4_0/gpdk045/../models/spectre/gpdk045.scs" "tt")
)
run()
v\ \/V4_PLUS\;\ tran\ \(V\) = vtime('tran "/V4_PLUS")
plot( v\ \/V4_PLUS\;\ tran\ \(V\) ?expr '( "v /V4_PLUS; tran (V)" ) )
v\ \/I0_OUT\;\ tran\ \(V\) = vtime('tran "/I0_OUT")
plot( v\ \/I0_OUT\;\ tran\ \(V\) ?expr '( "v /I0_OUT; tran (V)" ) )
modelFile(
    '("/ubc/ece/data/cmc2/kits/AMSKIT616_GPDK/tech/gpdk045_v_4_0/gpdk045/../models/spectre/gpdk045.scs" "tt")
)
run()
v\ \/V4_PLUS\;\ tran\ \(V\) = vtime('tran "/V4_PLUS")
plot( v\ \/V4_PLUS\;\ tran\ \(V\) ?expr '( "v /V4_PLUS; tran (V)" ) )
v\ \/I0_OUT\;\ tran\ \(V\) = vtime('tran "/I0_OUT")
plot( v\ \/I0_OUT\;\ tran\ \(V\) ?expr '( "v /I0_OUT; tran (V)" ) )
modelFile(
    '("/ubc/ece/data/cmc2/kits/AMSKIT616_GPDK/tech/gpdk045_v_4_0/gpdk045/../models/spectre/gpdk045.scs" "tt")
)
run()
v\ \/V4_PLUS\;\ tran\ \(V\) = vtime('tran "/V4_PLUS")
plot( v\ \/V4_PLUS\;\ tran\ \(V\) ?expr '( "v /V4_PLUS; tran (V)" ) )
v\ \/I0_OUT\;\ tran\ \(V\) = vtime('tran "/I0_OUT")
plot( v\ \/I0_OUT\;\ tran\ \(V\) ?expr '( "v /I0_OUT; tran (V)" ) )
modelFile(
    '("/ubc/ece/data/cmc2/kits/AMSKIT616_GPDK/tech/gpdk045_v_4_0/gpdk045/../models/spectre/gpdk045.scs" "tt")
)
run()
v\ \/V4_PLUS\;\ tran\ \(V\) = vtime('tran "/V4_PLUS")
plot( v\ \/V4_PLUS\;\ tran\ \(V\) ?expr '( "v /V4_PLUS; tran (V)" ) )
v\ \/I0_OUT\;\ tran\ \(V\) = vtime('tran "/I0_OUT")
plot( v\ \/I0_OUT\;\ tran\ \(V\) ?expr '( "v /I0_OUT; tran (V)" ) )
modelFile(
    '("/ubc/ece/data/cmc2/kits/AMSKIT616_GPDK/tech/gpdk045_v_4_0/gpdk045/../models/spectre/gpdk045.scs" "tt")
)
run()
v\ \/V4_PLUS\;\ tran\ \(V\) = vtime('tran "/V4_PLUS")
plot( v\ \/V4_PLUS\;\ tran\ \(V\) ?expr '( "v /V4_PLUS; tran (V)" ) )
v\ \/I0_OUT\;\ tran\ \(V\) = vtime('tran "/I0_OUT")
plot( v\ \/I0_OUT\;\ tran\ \(V\) ?expr '( "v /I0_OUT; tran (V)" ) )
modelFile(
    '("/ubc/ece/data/cmc2/kits/AMSKIT616_GPDK/tech/gpdk045_v_4_0/gpdk045/../models/spectre/gpdk045.scs" "tt")
)
run()
v\ \/V4_PLUS\;\ tran\ \(V\) = vtime('tran "/V4_PLUS")
plot( v\ \/V4_PLUS\;\ tran\ \(V\) ?expr '( "v /V4_PLUS; tran (V)" ) )
v\ \/I0_OUT\;\ tran\ \(V\) = vtime('tran "/I0_OUT")
plot( v\ \/I0_OUT\;\ tran\ \(V\) ?expr '( "v /I0_OUT; tran (V)" ) )
modelFile(
    '("/ubc/ece/data/cmc2/kits/AMSKIT616_GPDK/tech/gpdk045_v_4_0/gpdk045/../models/spectre/gpdk045.scs" "tt")
)
run()
v\ \/V4_PLUS\;\ tran\ \(V\) = vtime('tran "/V4_PLUS")
plot( v\ \/V4_PLUS\;\ tran\ \(V\) ?expr '( "v /V4_PLUS; tran (V)" ) )
v\ \/I0_OUT\;\ tran\ \(V\) = vtime('tran "/I0_OUT")
plot( v\ \/I0_OUT\;\ tran\ \(V\) ?expr '( "v /I0_OUT; tran (V)" ) )
modelFile(
    '("/ubc/ece/data/cmc2/kits/AMSKIT616_GPDK/tech/gpdk045_v_4_0/gpdk045/../models/spectre/gpdk045.scs" "tt")
)
run()
v\ \/V4_PLUS\;\ tran\ \(V\) = vtime('tran "/V4_PLUS")
plot( v\ \/V4_PLUS\;\ tran\ \(V\) ?expr '( "v /V4_PLUS; tran (V)" ) )
v\ \/I0_OUT\;\ tran\ \(V\) = vtime('tran "/I0_OUT")
plot( v\ \/I0_OUT\;\ tran\ \(V\) ?expr '( "v /I0_OUT; tran (V)" ) )
modelFile(
    '("/ubc/ece/data/cmc2/kits/AMSKIT616_GPDK/tech/gpdk045_v_4_0/gpdk045/../models/spectre/gpdk045.scs" "tt")
)
run()
v\ \/V4_PLUS\;\ tran\ \(V\) = vtime('tran "/V4_PLUS")
plot( v\ \/V4_PLUS\;\ tran\ \(V\) ?expr '( "v /V4_PLUS; tran (V)" ) )
v\ \/I0_OUT\;\ tran\ \(V\) = vtime('tran "/I0_OUT")
plot( v\ \/I0_OUT\;\ tran\ \(V\) ?expr '( "v /I0_OUT; tran (V)" ) )
modelFile(
    '("/ubc/ece/data/cmc2/kits/AMSKIT616_GPDK/tech/gpdk045_v_4_0/gpdk045/../models/spectre/gpdk045.scs" "tt")
)
run()
v\ \/V4_PLUS\;\ tran\ \(V\) = vtime('tran "/V4_PLUS")
plot( v\ \/V4_PLUS\;\ tran\ \(V\) ?expr '( "v /V4_PLUS; tran (V)" ) )
v\ \/I0_OUT\;\ tran\ \(V\) = vtime('tran "/I0_OUT")
plot( v\ \/I0_OUT\;\ tran\ \(V\) ?expr '( "v /I0_OUT; tran (V)" ) )
modelFile(
    '("/ubc/ece/data/cmc2/kits/AMSKIT616_GPDK/tech/gpdk045_v_4_0/gpdk045/../models/spectre/gpdk045.scs" "tt")
)
run()
v\ \/V4_PLUS\;\ tran\ \(V\) = vtime('tran "/V4_PLUS")
plot( v\ \/V4_PLUS\;\ tran\ \(V\) ?expr '( "v /V4_PLUS; tran (V)" ) )
v\ \/I0_OUT\;\ tran\ \(V\) = vtime('tran "/I0_OUT")
plot( v\ \/I0_OUT\;\ tran\ \(V\) ?expr '( "v /I0_OUT; tran (V)" ) )
modelFile(
    '("/ubc/ece/data/cmc2/kits/AMSKIT616_GPDK/tech/gpdk045_v_4_0/gpdk045/../models/spectre/gpdk045.scs" "tt")
)
run()
v\ \/V4_PLUS\;\ tran\ \(V\) = vtime('tran "/V4_PLUS")
plot( v\ \/V4_PLUS\;\ tran\ \(V\) ?expr '( "v /V4_PLUS; tran (V)" ) )
v\ \/I0_OUT\;\ tran\ \(V\) = vtime('tran "/I0_OUT")
plot( v\ \/I0_OUT\;\ tran\ \(V\) ?expr '( "v /I0_OUT; tran (V)" ) )
modelFile(
    '("/ubc/ece/data/cmc2/kits/AMSKIT616_GPDK/tech/gpdk045_v_4_0/gpdk045/../models/spectre/gpdk045.scs" "tt")
)
run()
v\ \/V4_PLUS\;\ tran\ \(V\) = vtime('tran "/V4_PLUS")
plot( v\ \/V4_PLUS\;\ tran\ \(V\) ?expr '( "v /V4_PLUS; tran (V)" ) )
v\ \/I0_OUT\;\ tran\ \(V\) = vtime('tran "/I0_OUT")
plot( v\ \/I0_OUT\;\ tran\ \(V\) ?expr '( "v /I0_OUT; tran (V)" ) )
modelFile(
    '("/ubc/ece/data/cmc2/kits/AMSKIT616_GPDK/tech/gpdk045_v_4_0/gpdk045/../models/spectre/gpdk045.scs" "tt")
)
run()
v\ \/V4_PLUS\;\ tran\ \(V\) = vtime('tran "/V4_PLUS")
plot( v\ \/V4_PLUS\;\ tran\ \(V\) ?expr '( "v /V4_PLUS; tran (V)" ) )
v\ \/I0_OUT\;\ tran\ \(V\) = vtime('tran "/I0_OUT")
plot( v\ \/I0_OUT\;\ tran\ \(V\) ?expr '( "v /I0_OUT; tran (V)" ) )
modelFile(
    '("/ubc/ece/data/cmc2/kits/AMSKIT616_GPDK/tech/gpdk045_v_4_0/gpdk045/../models/spectre/gpdk045.scs" "tt")
)
run()
v\ \/V4_PLUS\;\ tran\ \(V\) = vtime('tran "/V4_PLUS")
plot( v\ \/V4_PLUS\;\ tran\ \(V\) ?expr '( "v /V4_PLUS; tran (V)" ) )
v\ \/I0_OUT\;\ tran\ \(V\) = vtime('tran "/I0_OUT")
plot( v\ \/I0_OUT\;\ tran\ \(V\) ?expr '( "v /I0_OUT; tran (V)" ) )
