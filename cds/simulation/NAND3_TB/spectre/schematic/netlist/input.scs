// Design: ELEC402/NAND3_TB
simulator lang=spectre
global 0
parameters T=5n
include "/ubc/ece/data/cmc2/kits/AMSKIT616_GPDK/tech/gpdk045_v_4_0/gpdk045/../models/spectre/gpdk045.scs" section=tt

// ELEC402/NAND3/schematic
subckt NAND3 A B C GND OUT VDD
    NM2 (OUT A NM1_D GND) g45n1svt w=(400n) l=120n nf=1 m=(1)
    NM1 (NM1_D B NM0_D GND) g45n1svt w=(400n) l=120n nf=1 m=(1)
    NM0 (NM0_D C GND GND) g45n1svt w=(400n) l=120n nf=1 m=(1)
    PM2 (OUT C VDD VDD) g45p1svt w=(160n) l=120n nf=1 m=(1)
    PM1 (OUT B VDD VDD) g45p1svt w=(160n) l=120n nf=1 m=(1)
    PM0 (OUT A VDD VDD) g45p1svt w=(160n) l=120n nf=1 m=(1)
ends NAND3

// ELEC402/NAND3_TB/schematic
I0 (V4_PLUS V1_PLUS V2_PLUS 0 I0_OUT I0_VDD) NAND3
V1 (V1_PLUS 0) vsource dc=1 type=dc
V2 (V2_PLUS 0) vsource dc=1 type=dc
V0 (I0_VDD 0) vsource dc=1 type=dc
V4 (V4_PLUS 0) vsource type=pulse val0=0 val1=1 period=T rise=10p fall=10p
C0 (I0_OUT 0) capacitor c=10f
simulatorOptions options temp=27
tran tran stop=25n
